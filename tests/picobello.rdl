// Copyright 2025 ETH Zurich and University of Bologna.
// Solderpad Hardware License, Version 0.51, see LICENSE for details.
// SPDX-License-Identifier: SHL-0.51

// AUTOMATICALLY GENERATED! DO NOT EDIT!

// Copyright 2025 ETH Zurich and University of Bologna.
// Solderpad Hardware License, Version 0.51, see LICENSE for details.
// SPDX-License-Identifier: SHL-0.51




addrmap cheshire_external {
    external mem {
        mementries = 1;
        memwidth = 64;
    } dummy;

};

 // __CHESHIRE_EXTERNAL_RDL__

// Copyright 2025 ETH Zurich and University of Bologna.
// Solderpad Hardware License, Version 0.51, see LICENSE for details.
// SPDX-License-Identifier: SHL-0.51




// `include "cheshire.rdl"
// `include "serial_link_single_channel.rdl"
// Copyright 2025 ETH Zurich and University of Bologna.
// Solderpad Hardware License, Version 0.51, see LICENSE for details.
// SPDX-License-Identifier: SHL-0.51




addrmap pb_soc_regs #(
    longint unsigned Num_Clusters = 16,
    longint unsigned Num_Mem_Tiles = 8,
    longint unsigned Num_SPUs = 1
) {
    reg clk_control #(
        longint unsigned NumClkEnables = 32
    ) {
       desc = "Clock gate Control Register for SoC tiles";
        field {
            name = "clk_enable";
            desc = "Clock gate control for SoC tiles";
            hw = r;
            sw = rw;
            reset = 0;
        } clk_en [NumClkEnables-1:0];
    };

    reg rst_control #(
        longint unsigned NumResets = 32
    ) {
        desc = "Reset Control Register for SoC tiles";
        field {
            name = "rst";
            desc = "Reset control for SoC tiles";
            hw = r;
            sw = rw;
            reset = 0;
        } rst [NumResets-1:0];
    };

    clk_control #(.NumClkEnables(Num_Clusters) )    cluster_clk_enables;
    clk_control #(.NumClkEnables(Num_Mem_Tiles) )   mem_tile_clk_enables;
    clk_control #(.NumClkEnables(Num_SPUs) )        fhg_spu_clk_enables;
    rst_control #(.NumResets(Num_Clusters) )        cluster_rsts;
    rst_control #(.NumResets(Num_Mem_Tiles) )       mem_tile_rsts;
    rst_control #(.NumResets(Num_SPUs) )            fhg_spu_rsts;
};

 // __PB_SOC_REGS_RDL__




addrmap cheshire_tile {

    // cheshire #(
    //     .SlinkNumBits (16)
    // )                               cheshire          @0x0000_0000;

    // serial_link_single_channel_reg  dram_serial_link  @0x1800_0000;

    pb_soc_regs  pb_soc_regs   @0x1800_3000;

};

 // __CHESHIRE_TILE_RDL__

// Copyright 2025 ETH Zurich and University of Bologna.
// Solderpad Hardware License, Version 0.51, see LICENSE for details.
// SPDX-License-Identifier: SHL-0.51




addrmap fhg_spu_tile {

    external mem {
        mementries = 1;
        memwidth = 64;
    } dummy;


};

 // __FHG_SPU_TILE_RDL__

// Copyright 2025 ETH Zurich and University of Bologna.
// Solderpad Hardware License, Version 0.51, see LICENSE for details.
// SPDX-License-Identifier: SHL-0.51

// AUTOMATICALLY GENERATED by clustergen.py; edit the script or configuration
// instead.






// Copyright 2025 ETH Zurich and University of Bologna.
// Solderpad Hardware License, Version 0.51, see LICENSE for details.
// SPDX-License-Identifier: SHL-0.51




addrmap snitch_cluster_peripheral_reg #(
    longint unsigned NumPerfCounters = 16,
    longint unsigned NumCtrlScratch = 4
) {
    default regwidth=64;

    reg perf_cnt_en {
        field {
            name = "enable";
            desc = "Enable a particular performance counter to start tracking.";
            hw = r;
            sw = rw;
        } enable[0:0] = 1;
    };

    enum perf_metric {
        cycle = 0 {
            desc = "Cycle counter. Counts up as long as the cluster is powered.";
        };
        tcdm_accessed = 1 {
            desc = "Increased whenever the TCDM is accessed. Each individual access is tracked,
                    so if `n` cores access the TCDM, `n` will be added. Accesses are tracked at the TCDM,
                    so it doesn't matter whether the cores or for example the SSR hardware accesses
                    the TCDM. _This is a cluster-global signal._";
        };
        tcdm_congested = 2 {
            desc = "Incremented whenever an access towards the TCDM is made but the arbitration
                    logic didn't grant the access (due to congestion). It's strictly less than tcdm_accessed.
                    _This is a cluster-global signal._";
        };
        issue_fpu = 3 {
            desc = "Operations performed in the FPU. Includes both operations initiated by the
                    sequencer and by the core. When the Xfrep extension is available, this counter is
                    equivalent to issue_fpu_seq (see description of issue_fpu_seq). If the Xfrep extension
                    is not supported, then it is equivalent to issue_core_to_fpu. _This is a hart-local signal._";
        };
        issue_fpu_seq = 4 {
            desc = "Incremented whenever the FPU Sequencer issues an FPU instruction.
                    Might not be available if the hardware doesn't support FREP.
                    Note that all FP instructions offloaded by the core to the FPU are routed
                    through the sequencer (although not necessarily buffered) and thus are also counted.
                    The instructions issued independently by the FPU sequencer could thus be
                    calculated as issue_fpu_seq_proper = issue_fpu_seq - issue_core_to_fpu.
                    _This is a hart-local signal._";
        };
        issue_core_to_fpu = 5 {
            desc = "Incremented whenever the core issues an FPU instruction.
                    _This is a hart-local signal._";
        };
        retired_instr = 6 {
            desc = "Instructions retired by the core, both offloaded and not. Does not
                    count instructions issued independently by the FPU sequencer.
                    _This is a hart-local signal._";
        };
        retired_load = 7 {
            desc = "Load instructions retired by the core. _This is a hart-local signal._";
        };
        retired_i = 8 {
            desc = "Base instructions retired by the core. _This is a hart-local signal._";
        };
        retired_acc = 9 {
            desc = "Offloaded instructions retired by the core. _This is a hart-local signal._";
        };
        dma_aw_stall = 10 {
            desc = "Incremented whenever aw_valid = 1 but aw_ready = 0.
                    _This is a DMA-local signal_";
        };
        dma_ar_stall = 11 {
            desc = "Incremented whenever ar_valid = 1 but ar_ready = 0.
                    _This is a DMA-local signal_";
        };
        dma_r_stall = 12 {
            desc = "Incremented whenever r_ready = 1 but r_valid = 0.
                    _This is a DMA-local signal_";
        };
        dma_w_stall = 13 {
            desc = "Incremented whenever w_valid = 1 but w_ready = 0.
                    _This is a DMA-local signal_";
        };
        dma_buf_w_stall = 14 {
            desc = "Incremented whenever w_ready = 1 but w_valid = 0.
                    _This is a DMA-local signal_";
        };
        dma_buf_r_stall = 15 {
            desc = "Incremented whenever r_valid = 1 but r_ready = 0.
                    _This is a DMA-local signal_";
        };
        dma_aw_done = 16 {
            desc = "Incremented whenever AW handshake occurs.
                    _This is a DMA-local signal_";
        };
        dma_aw_bw = 17 {
            desc = "Whenever AW handshake occurs, the counter is incremented
                    by the number of bytes transfered for this transaction
                    _This is a DMA-local signal_";
        };
        dma_ar_done = 18 {
            desc = "Incremented whenever AR handshake occurs.
                    _This is a DMA-local signal_";
        };
        dma_ar_bw = 19 {
            desc = "Whenever AR handshake occurs, the counter is incremented
                    by the number of bytes transfered for this transaction
                    _This is a DMA-local signal_";
        };
        dma_r_done = 20 {
            desc = "Incremented whenever R handshake occurs.
                    _This is a DMA-local signal_";
        };
        dma_r_bw = 21 {
            desc = "Whenever R handshake occurs, the counter is incremented
                    by the number of bytes transfered in this cycle
                    _This is a DMA-local signal_";
        };
        dma_w_done = 22 {
            desc = "Incremented whenvever W handshake occurs.
                    _This is a DMA-local signal_";
        };
        dma_w_bw = 23 {
            desc = "Whenever W handshake occurs, the counter is incremented
                    by the number of bytes transfered in this cycle
                    _This is a DMA-local signal_";
        };
        dma_b_done = 24 {
            desc = "Incremented whenever B handshake occurs.
                    _This is a DMA-local signal_";
        };
        dma_busy = 25 {
            desc = "Incremented whenever DMA is busy.
                    _This is a DMA-local signal_";
        };
        icache_miss = 26 {
            desc = "Incremented for instruction cache misses.
                    _This is a hart-local signal_";
        };
        icache_hit = 27 {
            desc = "Incremented for instruction cache hits.
                    _This is a hart-local signal_";
        };
        icache_prefetch = 28 {
            desc = "Incremented for instruction cache prefetches.
                    _This is a hart-local signal_";
        };
        icache_double_hit = 29 {
            desc = "Incremented for instruction cache double hit.
                    _This is a hart-local signal_";
        };
        icache_stall = 30 {
            desc = "Incremented for instruction cache stalls.
                    _This is a hart-local signal_";
        };
    };

    reg perf_cnt_sel {
        desc = "Select the metric that is tracked for each performance counter.";
        field {
            name = "hart";
            desc = "Select from which hart in the cluster, starting from `0`,
                    the event should be counted. For each performance counter
                    the cores can be selected individually. If a hart greater
                    than the cluster's total hart size is selected the selection
                    will wrap and the hart corresponding to `hart_select % total_harts_in_cluster`
                    will be selected.";
            hw = rw;
            sw = rw;
        } hart[15:0];
        field {
            name = "metric";
            desc = "Select the metric that is tracked for each performance counter";
            hw = rw;
            sw = rw;
            encode = perf_metric;
        } metric[31:16];
    };

    reg perf_cnt {
        desc = "Performance counter. Set corresponding perf_cnt_sel register depending on what
                performance metric and hart you would like to track.";
        field {
            desc = "Performance counter";
            hw = rw;
            sw = rw;
            onwrite = wclr;
        } perf_counter[47:0];
    };

    reg scratch {
        desc = "Scratch registers. Used in the bootrom for various purposes.";
        field {
            desc = "Scratch register";
            hw = na;
            sw = rw;
        } scratch[31:0] = 0;
    };

    reg cl_clint_set {
        desc = "Set bits in the cluster-local CLINT. Writing a 1 at location i sets the cluster-local interrupt
                of hart i, where i is relative to the first hart in the cluster, ignoring the cluster base hart ID.";
        field {
            desc = "Set cluster-local interrupt of hart i";
            sw = w;
            hw = r;
        } cl_clint_set[31:0];
    };

    reg cl_clint_clear {
        desc = "Clear bits in the cluster-local CLINT. Writing a 1 at location i clears the cluster-local interrupt
                of hart i, where i is relative to the first hart in the cluster, ignoring the cluster base hart ID.";
        field {
            desc = "Set cluster-local interrupt of hart i";
            sw = w;
            hw = r;
        } cl_clint_clear[31:0];
    };

    reg icache_prefetch_enable {
        desc = "Controls prefetching of the instruction cache.";
        field {
            desc = "Enable instruction prefetching.";
            hw = r;
            sw = w;
        } icache_prefetch_enable[0:0] = 1;
    };

    // Required for PeakRDL to define the `perf_metric` enum in
    // the generated RTL file, as this seems not to be done for
    // for registers defined to be `external`.
    reg unused {
        desc = "Unused register added to print enum";
        field {
            sw=r; hw=na;
            encode = perf_metric;
        } f[4:0] = 0;
    };

    regfile perf_regs {
                 perf_cnt_en            perf_cnt_en[NumPerfCounters];
        external perf_cnt_sel           perf_cnt_sel[NumPerfCounters];
        external perf_cnt               perf_cnt[NumPerfCounters];
    };

             perf_regs              perf_regs;
             scratch                scratch[NumCtrlScratch];
    external cl_clint_set           cl_clint_set;
    external cl_clint_clear         cl_clint_clear;
             icache_prefetch_enable icache_prefetch_enable;
             unused                 unused;
};

 // __SNITCH_CLUSTER_PERIPHERAL_REG_RDL__


addrmap snitch_cluster {

    default regwidth = 64;

    mem tcdm {
        mementries = 0x4000;
        memwidth = 64;
    };

    mem bootrom {
        mementries = 0x200;
        memwidth = 64;
    };

    mem zeromem {
        mementries = 0x1e00;
        memwidth = 64;
    };


    external tcdm                 tcdm           ;
    external bootrom              bootrom        @0x20000;
    snitch_cluster_peripheral_reg peripheral_reg @0x21000;
    external zeromem              zeromem        @0x30000;


};

 // __SNITCH_CLUSTER_RDL__



addrmap picobello_addrmap {

  cheshire_tile cheshire_internal @0x0;
  snitch_cluster cluster[16] @0x20000000 += 0x40000;
  fhg_spu_tile fhg_spu @0x40000000;
  external mem { mementries = 0x10000; memwidth = 32; } top_spm_narrow @0x60000000;
  external mem { mementries = 0x10000; memwidth = 32; } top_spm_wide @0x60040000;
  external mem { mementries = 0x40000; memwidth = 32; } l2_spm[8] @0x70000000 += 0x100000;
  cheshire_external cheshire_external @0x80000000;


};
